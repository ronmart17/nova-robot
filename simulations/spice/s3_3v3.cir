* S3 3V3
Vin vin 0 7.4
* --- COT buck Y
BYsw Ysw 0 V = v(Yon)*v(vin)
RYsw Ysw Yswr {(0.09+0.04)/2}
LY1 Yswr Ylx 3.3u ic=0.1
RYdcr Ylx v33 38m
BYiin vin 0 I = v(Yon)*i(LY1)
RYt v33 Yfb 31.6k
RYb Yfb 0 10k
CYff v33 Yfb 10p
RYinj Ysw Yrp 1k
CYinj Yrp 0 {8.333333333333334e-06/1k} ic=3.33
BYint 0 Yx I = 3.333e-06*(v(Yfb)-0.8)
CYint Yx 0 1n ic=0
RYhp Yrp Yrpf 1k
CYhp Yrpf 0 {1.6666666666666667e-05/1k} ic=3.33
BYfbm Yfbm 0 V = v(Yfb) + max(-0.01099, min(0.01099, 0.08*(v(Yrp)-v(Yrpf)))) + v(Yx)
BYcmp Ycmp 0 V = 0.5*(1+tanh((0.8-v(Yfbm))*4000))
BYtrg Ytrg 0 V = v(Ycmp)*(1-v(Yon))*(1-v(Yblk))
BYnof Ynof 0 V = 1-v(Yon)
VYclr Yclr 0 0
AYon Ytrg vin Yclr Yon YON
.model YON oneshot(cntl_array=[3 4 5 6 7 8 9 10 12 15 18 24] pw_array=[8.16667e-07 6.9375e-07 5.55e-07 4.625e-07 3.96429e-07 3.46875e-07 3.08333e-07 2.775e-07 2.3125e-07 1.85e-07 1.54167e-07 1.15625e-07] clk_trig=0.5 pos_edge_trig=true out_low=0 out_high=1 rise_delay=2n fall_delay=2n retrig=false)
AYbk Ynof vin Yclr Yblk YBK
.model YBK oneshot(cntl_array=[0 30] pw_array=[1.4e-07 1.4e-07] clk_trig=0.5 pos_edge_trig=true out_low=0 out_high=1 rise_delay=1n fall_delay=1n retrig=false)
Co v33 co 26u ic=3.33
Rco co 0 2m
C326 v33 0 100n
Il v33 0 PWL(0 0.1 2.0m 0.1 2.001m 0.6 2.3m 0.6 2.301m 0.1)
.option method=gear reltol=1e-3
.tran 1n 2.6m 0 1n uic
.meas tran vavg AVG v(v33) from=1.9m to=2.0m
.meas tran vpp PP v(v33) from=2.2m to=2.3m
.meas tran vpp0 PP v(v33) from=1.9m to=2.0m
.meas tran vmin MIN v(v33) from=2.0m to=2.2m
.meas tran vmax MAX v(v33) from=2.3m to=2.5m
.meas tran ilmax MAX i(LY1) from=2.0m to=2.3m
.control
set noaskquit
set wr_singlescale
set wr_vecnames
run
wrdata /home/claude/robot/sim/spice/s3_3v3.dat v(v33) i(LY1)
.endc
.end
