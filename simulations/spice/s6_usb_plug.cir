* S6 USB-C
Vs s 0 PWL(0 0 5u 0 5.05u 5)
Rc s c1 0.12
Lc c1 vbus 0.8u
C201 vbus cn 1u
Rc201 cn 0 5m
D201 0 vbus TVS12
R203 vbus det 100k
R204 det 0 200k
.model TVS12 D(Is=1e-12 N=1 Rs=0.9 BV=14.0 IBV=1m Cjo=170p)
.tran 1n 25u 0 1n
.meas tran vmax MAX v(vbus)
.meas tran vdet MAX v(det)
.control
set noaskquit
set wr_singlescale
set wr_vecnames
run
wrdata /home/claude/robot/sim/spice/s6_usb_plug.dat v(vbus) v(det)
.endc
.end
